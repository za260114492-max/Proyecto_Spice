* RC low-pass filter driven by an ideal AC voltage source
V1 1 0 AC 1 0
R1 1 2 1k
C1 2 0 1u
.AC DEC 10 10 100k
.END
