* ============================================================
* FILTRO ACTIVO PASA-BANDA
* Sallen-Key pasa-altas + RC pasa-bajas
* Opamp ideal (nullator + norator)
* ============================================================

.PARAM RA_VAL=1.27k
.PARAM RB_VAL=1.2k
.PARAM F0=1414
.PARAM MU=1e9

* ------------------------------------------------------------
* MODELO OPAMP IDEAL
* ------------------------------------------------------------

.SUBCKT OPAMP_IDEAL inp inn out
E_NULOR out 0 inp inn 'MU'
.ENDS OPAMP_IDEAL

* ------------------------------------------------------------
* FUENTE DE ENTRADA
* ------------------------------------------------------------

V1 1 0 DC 0 AC 1m SIN(0 1m F0)

* ------------------------------------------------------------
* ETAPA 1: SALLEN-KEY PASA-ALTAS
* Frecuencia natural aproximada = 1 kHz
* ------------------------------------------------------------

C1 1 2 100n
C2 2 3 100n

R_G1 2 5 1.27k
R_G2 3 0 2k

* Red de ganancia

R_B 5 4 RB_VAL
R_A 4 0 RA_VAL

* Amplificador operacional ideal

X_A1 3 4 5 OPAMP_IDEAL

* ------------------------------------------------------------
* ETAPA 2: RC PASA-BAJAS
* Frecuencia de corte aproximada = 1.96 kHz
* ------------------------------------------------------------

R_F 5 6 1k
C_F 6 0 82n

* Carga

R_L 6 0 100k

* ------------------------------------------------------------
* ANALISIS AC
* ------------------------------------------------------------

.AC DEC 100 10 5k

* ------------------------------------------------------------
* ANALISIS TRANSITORIO
* ------------------------------------------------------------

.TRAN 5u 20m

* ------------------------------------------------------------
* RESULTADOS AC
* ------------------------------------------------------------

.PRINT AC V(1) V(5) V(6) VDB(6) VP(6)

* ------------------------------------------------------------
* RESULTADOS TRANSITORIOS
* ------------------------------------------------------------

.PRINT TRAN V(1) V(5) V(6)

* ------------------------------------------------------------
* PROBES
* ------------------------------------------------------------

.PROBE AC V(1) V(2) V(3) V(4) V(5) V(6)
.PROBE AC VDB(5) VDB(6) VP(6)

.PROBE TRAN V(1) V(5) V(6)

.OPTION POST=2 PROBE

.OP

.END
