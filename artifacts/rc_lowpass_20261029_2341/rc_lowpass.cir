* Circuito RC pasa-bajas

V1 IN 0 AC 1
R1 IN OUT 1k
C1 OUT 0 1u

.AC DEC 100 1 1MEG

.END
