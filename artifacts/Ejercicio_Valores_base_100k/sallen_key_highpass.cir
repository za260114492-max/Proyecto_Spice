* Filtro activo Sallen-Key pasa-altas - Opamp ideal (nullator + norator)
* Entrada senoidal Vi = 1 mV

.PARAM RA_VAL=1.27k
.PARAM RB_VAL=2.3k

* ---------------------------------------------------------------
* OPAMP IDEAL: tres ramas especiales
*   Rama 1 (entrada +):  I = 0
*   Rama 2 (entrada -):  I = 0   (en conjunto: V(inp) - V(inn) = 0)
*   Rama 3 (salida)   :  corriente adicional MNA I_o, tension libre
* En SPICE se realiza con una fuente E de ganancia muy alta: su estampa MNA es  V(out) - MU*(V(inp)-V(inn)) = 0  con incognita I_o.
* Cuando MU -> infinito la ecuacion es  V(inp) - V(inn) = 0.
* ---------------------------------------------------------------
.PARAM MU=1e9
.SUBCKT OPAMP_IDEAL inp inn out
E_NULOR out 0 inp inn 'MU'
.ENDS OPAMP_IDEAL

V1 1 0 DC 0 AC 1m

* Capacitores
C1 1 2 0.1u
C2 2 3 0.1u

* R_G1 = 1/G1 = RA ; R_G2 = 1/G2 = RB
R_G1 2 5 RA_VAL
R_G2 3 0 RB_VAL

* Red de ganancia
R_B 5 4 RB_VAL
R_A 4 0 RA_VAL

* Opamp ideal: (+)=3  (-)=4  salida=5
X_A1 3 4 5 OPAMP_IDEAL

.AC DEC 75 10 100k
.PRINT AC V(1) V(2) V(3) V(4) V(5) I(R_B) I(V1)
.PRINT AC VDB(5) VP(5)
.PROBE AC V(1) V(2) V(3) V(4) V(5) I(R_B) I(V1) VDB(5) VP(5)
.OPTION POST=2 PROBE
.OP
.END
